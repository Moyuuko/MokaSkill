let((moka_dir)
    ; 获取当前插件安装目录
    moka_dir = axlGetVariable("MOKA_INSTALL_DIR")
    if(!stringp(moka_dir) || strlen(moka_dir) == 0 then
        moka_dir = "D:/Moka_Skill"
    )
    moka_dir = axlOSSlash(moka_dir)

    axlSetVariable("MOKA_INSTALL_DIR" moka_dir)
    axlSetVariable("MOKA_UI_LANGUAGE" "ZH_CN")

    ; 将插件目录加入 SKILL 搜索路径
    setSkillPath(cons(moka_dir getSkillPath()))
)

defvar(_moka_menu_registered nil)

defun( moka_register_menu ()
    let((menu_items result)
        menu_items = '(
            (popup "&Moka skill")
            ("&\311\317\322\273\262\343" "moka_prev")
            ("&\317\302\322\273\262\343" "moka_next")
            ("&\265\245\262\343\040\057\040\266\340\262\343\317\324\312\276" "moka_all")
            ("&\304\243\312\275\307\320\273\273" "moka_mode")
            ("&\307\320\273\273\271\375\277\327" "moka_via")
            ("&\320\336\270\304\265\261\307\260\317\337\277\355" "moka_width")
            ("&\266\324\306\353\271\244\276\337\056\056\056" "moka_align")
            ("&\327\337\317\337\265\310\274\344\276\340\056\056\056" "moka_spread_between_clines")
            ("&\273\273\040\120\151\156\056\056\056" "moka_pin_swap")
            ("&\267\264\272\270\305\314\056\056\056" "moka_dp_antipad")
            ("&PCB\040\261\352\312\266\056\056\056" "moka_symbols")
            ("&\270\262\315\255\271\244\276\337\056\056\056" "moka_copper_corner")
            ("&\265\376\262\343\040\057\040\327\350\277\271\056\056\056" "moka_stackup_impedance")
            ("\275\273\273\245\312\275BOM" "moka_ibom_config")
            ("\307\345\300\355\271\244\263\314\310\325\326\276\056\056\056" "moka_clean_logs")
            (separator)
            ("&\327\337\317\337\267\326\316\366" "moka_ta")
            (separator)
            ("&\262\343\311\350\326\303\056\056\056" "mokaskill")
            (separator)
            ("&\120\103\102\040\320\305\317\242" "moka_info")
        )

        when(!_moka_menu_registered && isCallable('axlUIMenuRegister)
            result = errset(axlUIMenuRegister(-1 menu_items) t)
            when(result && car(result)
                _moka_menu_registered = t
            )
        )
    )
)

; 所有功能模块均以明文 SKILL 源码安装和加载。
when(isFile("moka_core.il")
    load("moka_core.il")
)
when(isFile("align_tools.il")
    load("align_tools.il")
)
when(isFile("spread_between_clines.il")
    load("spread_between_clines.il")
)
when(isFile("pin_swap.il")
    load("pin_swap.il")
)
when(isFile("dp_antipad.il")
    load("dp_antipad.il")
)
when(isFile("moka_copper_corner.il")
    load("moka_copper_corner.il")
)
when(isFile("stackup_impedance.il")
    load("stackup_impedance.il")
)
when(isFile("moka_interactive_bom.il")
    load("moka_interactive_bom.il")
)
when(isFile("allegro_cleanup.il")
    load("allegro_cleanup.il")
)

; Mooretronics Symbols 作为 MokaSkill 内置模块加载，资源保留在独立子目录。
let((moka_dir mts_dir mts_file)
    moka_dir = axlOSSlash(axlGetVariable("MOKA_INSTALL_DIR"))
    mts_dir = strcat(moka_dir "/mooretronics-symbols")
    mts_file = strcat(mts_dir "/mooretronics_symbols.il")
    when(isFile(mts_file)
        axlSetVariable("MTS_INSTALL_DIR" mts_dir)
        setSkillPath(cons(mts_dir getSkillPath()))
        load(mts_file)
    )
)

errset(moka_register_menu() t)
