let((moka_dir)
    ; Resolve and register the Moka Skill installation directory.
    moka_dir = axlGetVariable("MOKA_INSTALL_DIR")
    if(!stringp(moka_dir) || strlen(moka_dir) == 0 then
        moka_dir = "D:/Moka_Skill"
    )
    moka_dir = axlOSSlash(moka_dir)

    axlSetVariable("MOKA_INSTALL_DIR" moka_dir)
    ; Menu labels use the same CP936 octal strings as the feature panels.
    axlSetVariable("MOKA_UI_LANGUAGE" "ZH_CN")
    setSkillPath(cons(moka_dir getSkillPath()))
)

defvar(_moka_menu_registered nil)

defun( moka_register_menu ()
    let((menu_items result)
        menu_items = '(
            (popup "&Moka skill")
            ("&Previous Layer" "moka_prev")
            ("&Next Layer" "moka_next")
            ("Single / &Multi-Layer Display" "moka_all")
            ("Mode &Toggle" "moka_mode")
            ("&Via Toggle" "moka_via")
            ("Change Current Line &Width" "moka_width")
            ("&Alignment Tools..." "moka_align")
            ("Spread Between &Clines..." "moka_spread_between_clines")
            ("Pin &Swap..." "moka_pin_swap")
            ("Anti-Pa&d..." "moka_dp_antipad")
            ("PCB S&ymbols..." "moka_symbols")
            ("Copper &Tools..." "moka_copper_corner")
            ("Stackup / &Impedance..." "moka_stackup_impedance")
            ("Interactive &BOM..." "moka_ibom_config")
            ("Clean Project &Logs..." "moka_clean_logs")
            (separator)
            ("T&race Analysis" "moka_ta")
            (separator)
            ("&Layer Settings..." "mokaskill")
            (separator)
            ("PCB Information" "moka_info")
        )

        when(!_moka_menu_registered && isCallable('axlUIMenuRegister)
            result = errset(axlUIMenuRegister(-1 menu_items) t)
            when(result && car(result)
                _moka_menu_registered = t
            )
        )
    )
)

; Install and load every module as plain-text SKILL source.
when(isFile("moka_core.il")
    load("moka_core.il")
)
when(isFile("align_tools.il")
    load("align_tools.il")
)
when(isFile("spread_between_clines.il")
    load("spread_between_clines.il")
)
when(isFile("pin_swap.il")
    load("pin_swap.il")
)
when(isFile("dp_antipad.il")
    load("dp_antipad.il")
)
when(isFile("moka_copper_corner.il")
    load("moka_copper_corner.il")
)
when(isFile("stackup_impedance.il")
    load("stackup_impedance.il")
)
when(isFile("moka_interactive_bom.il")
    load("moka_interactive_bom.il")
)
when(isFile("allegro_cleanup.il")
    load("allegro_cleanup.il")
)

; Load Mooretronics Symbols as a built-in MokaSkill module.
let((moka_dir mts_dir mts_file)
    moka_dir = axlOSSlash(axlGetVariable("MOKA_INSTALL_DIR"))
    mts_dir = strcat(moka_dir "/mooretronics-symbols")
    mts_file = strcat(mts_dir "/mooretronics_symbols.il")
    when(isFile(mts_file)
        axlSetVariable("MTS_INSTALL_DIR" mts_dir)
        setSkillPath(cons(mts_dir getSkillPath()))
        load(mts_file)
    )
)

errset(moka_register_menu() t)
